* GF180 coarse/fine LC-DCO feasibility bench.
* PDK transistors, MIM capacitors, and MOS capacitors are modeled. The 3 nH,
* Q=10 inductor remains an explicit architecture assumption.

.include @@DESIGN_FILE@@
.lib @@MODEL_FILE@@ @@CORNER@@
.lib @@MODEL_FILE@@ @@MIM_CORNER@@
.lib @@MODEL_FILE@@ @@MOSCAP_CORNER@@

.param VDD_VALUE=1.8
.param TAIL_CURRENT=1m
.param TANK_L=3n
.param TANK_R=4.6
.temp @@TEMP_C@@

VDD vdd 0 {VDD_VALUE}
VCTRL vctrl 0 @@VCTRL@@

L1 vdd lp {TANK_L}
R1 lp outp {TANK_R}
L2 vdd ln {TANK_L}
R2 ln outn {TANK_R}

* Fixed 26 um square base capacitor on each branch.
XBASEP outp 0 cap_mim_1f5_m4m5_noshield c_width=26u c_length=26u
XBASEN outn 0 cap_mim_1f5_m4m5_noshield c_width=26u c_length=26u

* Selected 5 um square coarse cells are injected by the sweep script.
@@COARSE_CAPS@@

* Sixteen minimum 1 um square NMOS capacitors, represented by equal area.
XVARP outp vctrl cap_nmos_03v3 c_width=4u c_length=4u
XVARN outn vctrl cap_nmos_03v3 c_width=4u c_length=4u

XMN1 outp outn tail 0 nfet_03v3 l=0.28u w=40u nf=10
XMN2 outn outp tail 0 nfet_03v3 l=0.28u w=40u nf=10
ITAIL tail 0 {TAIL_CURRENT}
EDIFF diff 0 outp outn 1

.ic v(outp)=0.91 v(outn)=0.89 v(tail)=0.4
.option method=gear reltol=1e-4
.tran 5p 500n uic

.measure tran fifty_periods
+ TRIG v(diff) VAL=0 RISE=1 TD=400n
+ TARG v(diff) VAL=0 RISE=51 TD=400n
.measure tran frequency_hz PARAM='50/fifty_periods'
.measure tran differential_vpp PP v(diff) FROM=400n TO=500n
.measure tran supply_current_a AVG i(VDD) FROM=400n TO=500n
.measure tran power_w PARAM='-supply_current_a*VDD_VALUE'

.end
