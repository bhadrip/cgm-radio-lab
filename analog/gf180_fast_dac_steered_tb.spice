* Nominal GF180 current-steered fast-DAC bench.
* Every mirror branch steers continuously between matched output and dummy loads.

.include @@DESIGN_FILE@@
.lib @@MODEL_FILE@@ @@CORNER@@

.param VDD_VALUE=1.8
.param BASE_VOLTAGE=1.192
.param UNIT_CURRENT=125.984251968n
.temp @@TEMP_C@@

VDD vdd 0 {VDD_VALUE}
VBASE vbase 0 {BASE_VOLTAGE}
RLOAD out vbase 1k
CLOAD out 0 10p
RDUMMY dummy vbase 1k
CDUMMY dummy 0 10p

IREF vbp 0 {UNIT_CURRENT}
XREF vbp vbp vdd vdd pfet_03v3 l=1u w=1u nf=1

@@CONTROL_SOURCES@@
 @@DAC_CELLS@@

.option method=gear reltol=1e-4 numdgt=12
.tran @@TIME_STEP@@ @@STOP_TIME@@

@@MEASUREMENTS@@

.control
set numdgt=15
run
quit
.endc

.end
